* Kinux fixture: a fixed-duty buck with an OPEN feedback loop.
* Written for Kinux (not copied from any other project). Its structure is the one the fang buck deck
* in spikes/fang has: a divider R2/R1 is drawn from the output to the converter's FB pin, but the
* converter model is a fixed-duty switch pair with no control loop, so nothing ever reads FB.
* The 12 V -> 3.3 V ratio comes from the duty (0.275), not from feedback.
Vin 3 0 DC 12
XU1 3 0 sw fb en buck
L1 sw out 4.7u
C1 out 0 22u
RL out 0 2.2
R2 out fb 200k
R1 fb 0 64k
.subckt buck vin gnd sw fb en
Vh hc gnd PULSE(0 1 0 2n 2n 218n 800n)
Vl lc gnd PULSE(1 0 0 2n 2n 218n 800n)
Sh vin sw hc gnd swm
Sl sw gnd lc gnd swm
.model swm SW(Ron=0.01 Roff=1e6 Vt=0.5 Vh=0.1)
Rfb fb gnd 1e9
Ren en gnd 1e6
.ends buck
.end
