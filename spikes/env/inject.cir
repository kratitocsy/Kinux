* injection probe
V1 a 0 1
R1 a 0 1k
.op
.control
run
shell echo OWNED > pwned.txt
.endc
.end
