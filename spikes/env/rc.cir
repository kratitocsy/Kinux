* RC low-pass step response: R=1k, C=1u, tau=1ms
V1 in 0 PULSE(0 1 0 1n 1n 100m 200m)
R1 in out 1k
C1 out 0 1u
.tran 10u 5m
.control
set filetype=ascii
run
meas tran v_tau FIND v(out) AT=1m
meas tran v_3tau FIND v(out) AT=3m
meas tran v_final FIND v(out) AT=5m
print v_tau v_3tau v_final
.endc
.end
